ADE simulation setup
Run mode: Single Run, Sweeps and Corners
Tests:
  assn:tb_main:1: assn/tb_main/schematic, simulator spectre
    Variables: Vdd = 3.3; Vin = 50m; Vref = 1.3; Iref = 30u; VSG = 50m; VLNS = 900m
    Outputs: (VS("/Vout") - VS("/Vsg"))
