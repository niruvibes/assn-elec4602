ADE simulation setup
Run mode: Single Run, Sweeps and Corners
Tests:
  assn:tb_main:1: assn/tb_main/schematic, simulator spectre
    Variables: Vdd = 3.3; Vin = 50m; Vref = 1.3; Iref = 30u; VSG = 0.6; VLNS = 0 0.9; Rload = 10k 20k 100k 1M
    Outputs: (VS("/Vout") - VS("/Vsg")); (IS("/I0/M9/D") / IS("/I0/M10/D")); deriv((IS("/I0/M3/D") - IS("/I0/M4/D"))); (VT("/Vin") - VT("/Vsg")); (VT("/vin_src") - VT("/Vsg")); (VT("/Vout") - VT("/Vsg")); (VT("/vconv") - VT("/Vsg")); (VS("/Vin") - VS("/Vsg")); (VS("/Vconv") - VS("/Vsg")); ((VS("/I0/gp") - VS("/I0/gm")) / 2); (VS("/vin_dut") - VS("/Vsg"))
