ADE simulation setup
Run mode: Single Run, Sweeps and Corners
Tests:
  assn:tb_main:1: assn/tb_main/schematic, simulator spectre
    Variables: Vdd = 3.0 3.3; Vin = 50m; Vref = 1.3; Iref = 30u; VSG = 0.6; VLNS = 0 0.9; Rload = 20k; Rs = 15k; VN = 0.5; VS0 = 0.443; VS1 = 0.469; VOS = 0.0243
    Outputs: (VT("/vin_src") - VT("/Vsg")); (VT("/Vout") - VT("/Vsg")); (VT("/vconv") - VT("/Vsg")); (VS("/Vout") - VS("/Vsg")); (VS("/VIn") - VS("/Vsg")); (VS("/Vin") - VS("/Vsg")); (VT("/Vin") - VT("/Vsg")); clip((VT("/Vin") - VT("/Vsg")) 0.0002 0.0003); clip((VT("/Vout") - VT("/Vsg")) 0.0002 0.0003)
Corners (all switched off):
  model folders: /usr/local/cadence/FreePDK45/ncsu_basekit/models/hspice
  FF: hspice_ff.include
  SF: hspice_sf.include
  FS: hspice_fs.include
  SS: hspice_ss.include
