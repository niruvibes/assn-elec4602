ADE simulation setup
Test assn:tb_main:1: assn/tb_main/schematic, simulator spectre
  Models: /usr/local/cadence/FreePDK45/ncsu_basekit/models/hspice/hspice_stat.include
  Variables: Vdd = 3.3; Vin = 50m; Vref = 1.3; Iref = 30u; VSG = 0.6; VLNS = 0; Rload = 1M; VN = 0.5; VS0 = 0.443; VS1 = 0.469; VOS = 0.0243
  Temperature: 27
  Analysis tran: stop=300u
  Output (VS("/Vout") - VS("/Vsg")) (unticked)
  Output (VS("/Vin") - VS("/Vsg")) (unticked)
  Output clip((VT("/Vin") - VT("/Vsg")) 0.0002 0.0003)
  Output clip((VT("/Vout") - VT("/Vsg")) 0.0002 0.0003)
