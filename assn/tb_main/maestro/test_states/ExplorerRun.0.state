ADE simulation setup
Test assn:tb_main:1: assn/tb_main/schematic, simulator spectre
  Models: /usr/local/cadence/FreePDK45/ncsu_basekit/models/hspice/hspice_stat.include
  Variables: Vdd = 3.3; Vin = 50m; Vref = 1.3; Iref = 30u; VSG = 50m; VLNS = 900m
  Temperature: 27
  Analysis dc: sweep Vin start=50m stop=500m step=5m
  Output (VS("/Vout") - VS("/Vsg"))
  Signals: /I0/gp, /I0/gm, /I0/Vbias (terminal), /I0/Vin (terminal), /I0/M4/D (terminal), /I0/M3/D (terminal), /I0/M5/D (terminal), /I0/M17/D (terminal), /I0/M7/D (terminal), /I0/M8/D (terminal), /I0/M9/D (terminal), /I0/M16/D (terminal), /I0/M15/D (terminal), /I0/M6/D (terminal), /vin_dut
