ADE simulation setup
Test assn:tb_main:1: assn/tb_main/schematic, simulator spectre
  Models: /usr/local/cadence/FreePDK45/ncsu_basekit/models/hspice/hspice_stat.include
  Variables: Vdd = 3.3; Vin = 50m; Vref = 1.3; Iref = 30u; VSG = 0.6; VLNS = 0; Rload = 20k
  Temperature: 27
  Analysis dc: sweep Vin start=0 stop=0.6 step=1m
  Output (VS("/Vout") - VS("/Vsg"))
  Output (VS("/Vin") - VS("/Vsg"))
