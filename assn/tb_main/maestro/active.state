ADE simulation setup
Test assn:tb_main:1: assn/tb_main/schematic, simulator spectre
  Models: /usr/local/cadence/FreePDK45/ncsu_basekit/models/hspice/hspice_stat.include
  Variables: Vdd = 3.3; Vin = 50m; Vref = 1.3; Iref = 30u; VSG = 0; VLNS = 0.9; Rload = 10000 20000 100000 1000000
  Temperature: 27
  Analysis dc: sweep Vin start=0 stop=1 step=5m
  Output (IS("/I0/M9/D") / IS("/I0/M10/D")) (unticked)
  Output deriv((IS("/I0/M3/D") - IS("/I0/M4/D"))) (unticked)
  Output (VS("/Vout") - VS("/Vsg"))
  Output (VS("/Vin") - VS("/Vsg")) (unticked)
  Output (VT("/Vin") - VT("/Vsg")) (unticked)
  Output (VT("/Vout") - VT("/Vsg")) (unticked)
  Output (VS("/Vconv") - VS("/Vsg"))
Run mode: Single Run, Sweeps and Corners
Corners:
  model folders: /usr/local/cadence/FreePDK45/ncsu_basekit/models/hspice
  FF: hspice_ff.include
  SF: hspice_sf.include
  FS: hspice_fs.include
  SS: hspice_ss.include
Setup values for test assn:tb_main:1: VSG = 0.6; VLNS = 0 0.9; Rload = 20k; VN = 0.5; VS0 = 0.443; VS1 = 0.469; VOS = 0.0243
