ADE simulation setup
Test assn:tb_main:1: assn/tb_main/schematic, simulator spectre
  Models: /usr/local/cadence/FreePDK45/ncsu_basekit/models/hspice/hspice_stat.include
  Variables: Vdd = 3.3; Vin = 50m; Vref = 1.3; Iref = 30u; VSG = 0; VLNS = 0.9
  Temperature: 27
  Analysis dc: sweep Vin start=0 stop=500m step=5m
  Output (VS("/Vout") - VS("/Vsg"))
  Output (IS("/I0/M9/D") / IS("/I0/M10/D"))
  Output deriv((IS("/I0/M3/D") - IS("/I0/M4/D")))
  Signals: /I0/Vbias (terminal), /I0/Vin (terminal), /I0/M4/D (terminal), /I0/M3/D (terminal), /I0/M5/D (terminal), /I0/M17/D (terminal), /I0/M7/D (terminal), /I0/M8/D (terminal), /I0/M9/D (terminal), /I0/M16/D (terminal), /I0/M15/D (terminal), /I0/M6/D (terminal), /I0/M12/D (terminal), /I0/boost, /I0/mirror_bias, /I0/M21/D (terminal), /I0/M10/D (terminal)
Run mode: Single Run, Sweeps and Corners
Corners:
  model folders: /usr/local/cadence/FreePDK45/ncsu_basekit/models/hspice
  FF: hspice_ff.include
  SF: hspice_sf.include
  FS: hspice_fs.include
  SS: hspice_ss.include
Setup values for test assn:tb_main:1: VSG = 0.6; VLNS = 0 0.9; Rload = 20k; VN = 0.5; VS0 = 0.443; VS1 = 0.469; VOS = 0.0243
