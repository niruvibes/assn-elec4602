ADE simulation setup
Test assn:tb_main:1: assn/tb_main/schematic, simulator spectre
  Models: /usr/local/cadence/FreePDK45/ncsu_basekit/models/hspice/hspice_stat.include
  Variables: Vdd = 3.0; Vin = 50m; Vref = 1.3; Iref = 30u; VSG = 0.6; VLNS = 0; Rload = 20k; Rs = 15k; VN = 0.5; VS0 = 0.443; VS1 = 0.469; VOS = 0.0243
  Temperature: 27
  Analysis tran: stop=300u
  Output (VS("/Vout") - VS("/Vsg")) (unticked)
  Output (VS("/Vin") - VS("/Vsg")) (unticked)
  Output clip((VT("/Vin") - VT("/Vsg")) 0.0002 0.0003) (unticked)
  Output clip((VT("/Vout") - VT("/Vsg")) 0.0002 0.0003) (unticked)
  Output ymax(clip((VT("/Vout") - VT("/Vsg")) 0.0002 0.0003)) (unticked)
  Output epsilon = ymax(clip((abs((VT("/Vout") - VT("/Vsg") - ((VAR("VS0") * ((VT("/Vin") - VT("/Vsg")) / VAR("VN")) * ((VT("/Vin") - VT("/Vsg")) / VAR("VN"))) + VAR("VOS")))) / (VT("/Vout") - VT("/Vsg"))) 0.0002 0.0003)) (unticked)
  Output delta_sq = ((value(VT("/Vout") 0.00025) - value(VT("/Vout") 0.000249)) / (value(VT("/Vout") 0.000201) - value(VT("/Vout") 0.0002))) (unticked)
  Output Vout_min = ymin(clip((VT("/Vout") - VT("/Vsg")) 0.0002 0.0003)) (unticked)
  Output epsilon_lin = ymax(clip((abs((VT("/Vout") - VT("/Vsg") - ((VAR("VS1") * ((VT("/Vin") - VT("/Vsg")) / VAR("VN"))) + VAR("VOS")))) / (VT("/Vout") - VT("/Vsg"))) 0.0002 0.0003)) (unticked)
  Output clip(((VAR("Vdd") * IT("/I0/Vdd")) - (VAR("VSG") * IT("/V4/PLUS"))) 0.0002 0.0003)
  Output integ(clip(((VAR("Vdd") * IT("/I0/Vdd")) - (VAR("VSG") * IT("/V4/PLUS"))) 0.0002 0.0003))
  Signals: /I0/Vdd (terminal), /V4/PLUS (terminal)
Run mode: Single Run, Sweeps and Corners
Corners:
  model folders: /usr/local/cadence/FreePDK45/ncsu_basekit/models/hspice
  FF: hspice_ff.include
  SF: hspice_sf.include
  FS: hspice_fs.include
  SS: hspice_ss.include
Setup values for test assn:tb_main:1: Vdd = 3.3; VLNS = 0 0.9
