ADE simulation setup
Test assn:tb_main:1: assn/tb_main/schematic, simulator spectre
  Models: /usr/local/cadence/FreePDK45/ncsu_basekit/models/hspice/hspice_stat.include
  Variables: Vdd = 3.3; Vin = 50m; Vref = 1.3; Iref = 30u; VSG = 0.6; VLNS = 0; Rload = 20k; Rs = 15k; VN = 0.5; VS0 = 0.443; VS1 = 0.469; VOS = 0.0243
  Temperature: 27
  Analysis dc: sweep Vin start=0 stop=0.6 step=1m
  Output (VS("/Vout") - VS("/Vsg"))
  Output (VS("/Vin") - VS("/Vsg"))
  Output clip((VT("/Vin") - VT("/Vsg")) 0.0002 0.0003) (unticked)
  Output clip((VT("/Vout") - VT("/Vsg")) 0.0002 0.0003) (unticked)
Run mode: Single Run, Sweeps and Corners
Corners:
  model folders: /usr/local/cadence/FreePDK45/ncsu_basekit/models/hspice
  FF: hspice_ff.include
  SF: hspice_sf.include
  FS: hspice_fs.include
  SS: hspice_ss.include
Setup values for test assn:tb_main:1: VLNS = 0 0.9
