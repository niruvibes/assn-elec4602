ADE simulation setup
Run mode: Single Run, Sweeps and Corners
Tests:
  assn:tb_inputDifferential:1: assn/tb_inputDifferential/schematic, simulator spectre
    Variables: vin_dc = 250m
    Outputs: /opAdd; /opSub; "/Vin"; /vbias; /Vin
