ADE simulation setup
Test assn:tb_inputDifferential:1: assn/tb_inputDifferential/schematic, simulator spectre
  Models: /usr/local/cadence/FreePDK45/ncsu_basekit/models/hspice/hspice_stat.include
  Variables: vin_dc = 250m
  Temperature: 27
  Analysis dc: sweep /V2.dc start=50m stop=500m step=55m
  Signals: /opAdd, /opSub, /net1, /vbias
Run mode: Single Run, Sweeps and Corners
