ADE simulation setup
Test assn:tb_levelShifter:1: assn/tb_levelShifter/schematic, simulator spectre
  Models: /usr/local/cadence/FreePDK45/ncsu_basekit/models/hspice/hspice_stat.include
  Variables: vtest = 0
  Temperature: 27
  Analysis dc: sweep /V0.dc start=0 stop=0.9 step=0.1
  Signals: /NlvlOut, /lvlOut, /net3, /I0/net018
Run mode: Single Run, Sweeps and Corners
