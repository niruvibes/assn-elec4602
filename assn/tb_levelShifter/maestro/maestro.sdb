ADE simulation setup
Run mode: Single Run, Sweeps and Corners
Tests:
  assn:tb_levelShifter:1: assn/tb_levelShifter/schematic, simulator spectre
    Variables: vtest = 0
    Outputs: "/NlvlOut"; /NlvlOut; /lvlOut; /net3
