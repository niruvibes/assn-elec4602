ADE simulation setup
Test assn:tb_opamp:1: assn/tb_opamp/schematic, simulator spectre
  Models: /usr/local/cadence/FreePDK45/ncsu_basekit/models/hspice/hspice_stat.include
  Variables: Vdc = 0
  Temperature: 27
  Analysis dc: sweep /V0.dc start=50m stop=500m step=5m
  Output (VS("/Vtest_in") - VS("/Vsg"))
  Output (VS("/Vout") - VS("/Vsg"))
Run mode: Single Run, Sweeps and Corners
