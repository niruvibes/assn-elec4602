ADE simulation setup
Run mode: Single Run, Sweeps and Corners
Tests:
  assn:tb_opamp:1: assn/tb_opamp/schematic, simulator spectre
    Variables: Vdc = 0
    Outputs: (VS("/Vtest_in") - VS("/Vsg")); (VS("/Vout") - VS("/Vsg"))
